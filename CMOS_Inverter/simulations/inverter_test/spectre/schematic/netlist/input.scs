// Design: CMOS_Inverter/inverter_test
simulator lang=spectre
global 0
include "/home/buet/cadence/gpdk090_v4.6/libs.oa22/gpdk090/../../models/spectre/gpdk090.scs" section=NN

// CMOS_Inverter/inverter/schematic
subckt inverter GND VDD Vin Vout
    NM0 (Vout Vin GND GND) gpdk090_nmos1v w=(2u) l=100n m=(1)*(1) simM=(1)*(1)
    PM0 (Vout Vin VDD VDD) gpdk090_pmos1v w=(5u) l=100n m=(1)*(1) simM=(1)*(1)
ends inverter

// CMOS_Inverter/inverter_test/schematic
I0 (0 net4 net5 Vout) inverter
V0 (net5 0) vsource type=pulse val0=0 val1=1 period=20n delay=0 rise=1n fall=1n width=10n
V1 (net4 0) vsource dc=1 type=dc
simulatorOptions options temp=27
tran tran stop=50n errpreset=moderate
dcOp dc
dc dc dev=V0 param=dc start=0 stop=1
